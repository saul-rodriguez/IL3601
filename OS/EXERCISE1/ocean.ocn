simulator( 'spectre )
design(	 "/home/saul/Sim/S3_PI/spectre/schematic/netlist/netlist")
resultsDir( "/home/saul/Sim/S3_PI/spectre/schematic" )
modelFile(
    '("/pkg/xfab/XKIT/xh018/cadence/v8_0/spectre/v8_0_1/lpmos/config.scs" "default")
    '("/pkg/xfab/XKIT/xh018/cadence/v8_0/spectre/v8_0_1/lpmos/param.scs" "3s")
    '("/pkg/xfab/XKIT/xh018/cadence/v8_0/spectre/v8_0_1/lpmos/bip.scs" "tm")
    '("/pkg/xfab/XKIT/xh018/cadence/v8_0/spectre/v8_0_1/lpmos/cap.scs" "tm")
    '("/pkg/xfab/XKIT/xh018/cadence/v8_0/spectre/v8_0_1/lpmos/dio.scs" "tm")
    '("/pkg/xfab/XKIT/xh018/cadence/v8_0/spectre/v8_0_1/lpmos/mos.scs" "tm")
    '("/pkg/xfab/XKIT/xh018/cadence/v8_0/spectre/v8_0_1/lpmos/photo.scs" "tm")
    '("/pkg/xfab/XKIT/xh018/cadence/v8_0/spectre/v8_0_1/lpmos/res.scs" "tm")
)
analysis('pz ?p ""  ?n ""  ?oprobe "/IPRB0"
		?iprobe "/I5"  ?porti "1"  )
analysis('ac ?start "100"  ?stop "300M"  )
desVar(	  "IT" 0	)
desVar(	  "cdb1" 1	)
desVar(	  "cdb4" 1	)
desVar(	  "cds1" 1	)
desVar(	  "cds4" 1	)
desVar(	  "cgd1" 1	)
desVar(	  "cgd4" 1	)
desVar(	  "cgs1" 1	)
desVar(	  "cgs4" 1	)
desVar(	  "gm1" 1	)
desVar(	  "gm4" 1	)
desVar(	  "R1" 100k	)
desVar(	  "R2" 400	)
desVar(	  "rds1" 1	)
desVar(	  "rds4" 1	)
envOption(
	'analysisOrder  list("ac" "pz")
)
save( 'i "/R0/PLUS" )
temp( 27 )
run()
selectResult( 'ac )
plot(getData("/R0/PLUS") )
pzPlot( ?result "pz")
