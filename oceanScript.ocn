simulator( 'spectre )
design(	 "/home/saul/Sim/TRANS/spectre/schematic/netlist/netlist")
resultsDir( "/home/saul/Sim/TRANS/spectre/schematic" )
modelFile(
    '("/pkg/xfab/XKIT/xh018/cadence/v8_0/spectre/v8_0_1/lpmos/config.scs" "default")
    '("/pkg/xfab/XKIT/xh018/cadence/v8_0/spectre/v8_0_1/lpmos/param.scs" "3s")
    '("/pkg/xfab/XKIT/xh018/cadence/v8_0/spectre/v8_0_1/lpmos/bip.scs" "tm")
    '("/pkg/xfab/XKIT/xh018/cadence/v8_0/spectre/v8_0_1/lpmos/cap.scs" "tm")
    '("/pkg/xfab/XKIT/xh018/cadence/v8_0/spectre/v8_0_1/lpmos/dio.scs" "tm")
    '("/pkg/xfab/XKIT/xh018/cadence/v8_0/spectre/v8_0_1/lpmos/mos.scs" "tm")
    '("/pkg/xfab/XKIT/xh018/cadence/v8_0/spectre/v8_0_1/lpmos/photo.scs" "tm")
    '("/pkg/xfab/XKIT/xh018/cadence/v8_0/spectre/v8_0_1/lpmos/res.scs" "tm")
)
analysis('ac ?start "0.1"  ?stop "100M"  ?dec "20"  )
analysis('pz ?p "/OUT"  ?iprobe "/I1"  ?param "gm1"
		?start "0"  ?stop "1.576m"  ?step ".05m"  )
desVar(	  "IT" 0	)
desVar(	  "IS" 1	)
desVar(	  "cdb1" 148f	)
desVar(	  "cds1" 229f	)
desVar(	  "cgd1" 33f	)
desVar(	  "cgs1" 478f	)
desVar(	  "gm1" 1.57m	)
desVar(	  "rds1" 579k	)
envOption(
	'analysisOrder  list("ac" "pz")
)
temp( 27 )
run()
selectResult( 'ac )
plot(getData("/OUT") )
