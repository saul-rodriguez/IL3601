ADE simulation setup
Run mode: Single Run, Sweeps and Corners
Tests:
  EXERCISE1:S7_BLOCK_TB:1 (off): EXERCISE1/S7_BLOCK_TB/schematic, simulator spectre
    Outputs: dB20(IF("/IPRB0/PLUS"))
  EXERCISE1:S7_BLOCK_TB:1:1 (off): EXERCISE1/S7_BLOCK_TB/schematic, simulator spectre
    Outputs: dB20(IF("/IPRB0/PLUS")); value(dB20(IF("/IPRB0/PLUS")) 100000); cross(dB20(IF("/IPRB0/PLUS")) "45" 1 "either" nil nil nil)
  EXERCISE1:S7_BLOCK_TB:1:2: EXERCISE1/S7_BLOCK_TB/schematic, simulator spectre
    Outputs: dB20(IF("/IPRB0/PLUS"))
Global variables:
  FREQ1 = 0
  FREQ2 = 0
  IN_AC = 0 (off)
  IN_AM1 = 0
  IN_AM2 = 0
  IPULSE = 0
  VD = 1.8
  VD_AC = 0
  VD_PULSE = 0 (off)
  IPULSE_BIAS = 0 (off)
Corners:
  model folders: /pkg/xfab/XKIT/xh018/cadence/v8_0/spectre/v8_0_1/lpmos
  C0 (off): temperature=-10 85; VD=1.62 1.98; param.scs[3s], bip.scs[tm], cap.scs[wp ws], dio.scs[tm], mos.scs[wo wp ws wz], photo.scs[tm], res.scs[wp ws]
