// Design: CHARACTERIZATION/MOS_AC_tb
simulator lang=spectre
global 0
parameters cdb1=1 cds1=1 cgd1=1 cgs1=1 gm1=1 rds1=1
include "/pkg/xfab/XKIT/xh018/cadence/v8_0/spectre/v8_0_1/lpmos/config.scs" section=default
include "/pkg/xfab/XKIT/xh018/cadence/v8_0/spectre/v8_0_1/lpmos/param.scs" section=3s
include "/pkg/xfab/XKIT/xh018/cadence/v8_0/spectre/v8_0_1/lpmos/bip.scs" section=tm
include "/pkg/xfab/XKIT/xh018/cadence/v8_0/spectre/v8_0_1/lpmos/cap.scs" section=tm
include "/pkg/xfab/XKIT/xh018/cadence/v8_0/spectre/v8_0_1/lpmos/dio.scs" section=tm
include "/pkg/xfab/XKIT/xh018/cadence/v8_0/spectre/v8_0_1/lpmos/mos.scs" section=tm
include "/pkg/xfab/XKIT/xh018/cadence/v8_0/spectre/v8_0_1/lpmos/photo.scs" section=tm
include "/pkg/xfab/XKIT/xh018/cadence/v8_0/spectre/v8_0_1/lpmos/res.scs" section=tm

// CHARACTERIZATION/MOS_AC/schematic
subckt MOS_AC D G S
parameters gm rds cgs cgd cdb cds
    G0 (D S G S) vccs gm=gm
    R0 (D S) resistor r=rds
    C5 (G S) capacitor c=cgs
    C4 (G D) capacitor c=cgd
    C3 (D S) capacitor c=cdb
    C0 (D S) capacitor c=cds
ends MOS_AC

// CHARACTERIZATION/MOS_AC_tb/schematic
I0 (net04 net1 0) MOS_AC gm=gm1 rds=rds1 cgs=cgs1 cgd=cgd1 cdb=cdb1 cds=cds1
V0 (net1 0) vsource type=sine
simulatorOptions options reltol=100e-6 temp=27 homotopy=all limit=delta compatible=spice2
