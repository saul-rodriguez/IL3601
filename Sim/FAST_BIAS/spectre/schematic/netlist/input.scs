// Design: CHARACTERIZATION/FAST_BIAS
simulator lang=spectre
global 0
parameters VDS1=1.0 IDS1=1e-06 NF1=1 L1=1.8e-07 WF1=1e-06
include "/pkg/xfab/XKIT/xh018/cadence/v8_0/spectre/v8_0_1/lpmos/config.scs" section=default
include "/pkg/xfab/XKIT/xh018/cadence/v8_0/spectre/v8_0_1/lpmos/param.scs" section=3s
include "/pkg/xfab/XKIT/xh018/cadence/v8_0/spectre/v8_0_1/lpmos/bip.scs" section=tm
include "/pkg/xfab/XKIT/xh018/cadence/v8_0/spectre/v8_0_1/lpmos/cap.scs" section=tm
include "/pkg/xfab/XKIT/xh018/cadence/v8_0/spectre/v8_0_1/lpmos/dio.scs" section=tm
include "/pkg/xfab/XKIT/xh018/cadence/v8_0/spectre/v8_0_1/lpmos/mos.scs" section=tm
include "/pkg/xfab/XKIT/xh018/cadence/v8_0/spectre/v8_0_1/lpmos/photo.scs" section=tm
include "/pkg/xfab/XKIT/xh018/cadence/v8_0/spectre/v8_0_1/lpmos/res.scs" section=tm

// CHARACTERIZATION/BIAS_NMOS/schematic
subckt BIAS_NMOS
parameters WF L NF IDS VDS
    M0 (D G 0 0) ne w=WF l=L m=(1)*(NF)
    I0 (0 D) isource dc=IDS type=dc
    V1 (net6 0) vsource dc=VDS type=dc
    E0 (G 0 D net6) vcvs gain=1000
ends BIAS_NMOS

// CHARACTERIZATION/FAST_BIAS/schematic
I0 BIAS_NMOS WF=WF1 L=L1 NF=NF1 IDS=IDS1 VDS=VDS1
simulatorOptions options reltol=100e-6 temp=27 homotopy=all limit=delta compatible=spice2
dcOp dc
