// Design: CHARACTERIZATION/FAST_BIAS
simulator lang=spectre
global 0
parameters VDS6=1.1 IDS6=3e-06 NF6=1 L6=3.5e-07 WF6=1.5e-05 VDS5=1.0 IDS5=2e-06 NF5=1 L5=2.5e-07 WF5=5e-06 VDS4=0.5 IDS4=1e-06 NF4=1 L4=1.8e-07 WF4=1e-05 VDS3=1.2 IDS3=1e-05 NF3=1 L3=5e-07 WF3=2e-05 VDS2=1.1 IDS2=2e-06 NF2=1 L2=3.5e-07 WF2=1.2e-05 VDS1=1.0 IDS1=1e-06 NF1=1 L1=1.8e-07 WF1=1e-06
include "/pkg/xfab/XKIT/xh018/cadence/v8_0/spectre/v8_0_1/lpmos/config.scs" section=default
include "/pkg/xfab/XKIT/xh018/cadence/v8_0/spectre/v8_0_1/lpmos/param.scs" section=3s
include "/pkg/xfab/XKIT/xh018/cadence/v8_0/spectre/v8_0_1/lpmos/bip.scs" section=tm
include "/pkg/xfab/XKIT/xh018/cadence/v8_0/spectre/v8_0_1/lpmos/cap.scs" section=tm
include "/pkg/xfab/XKIT/xh018/cadence/v8_0/spectre/v8_0_1/lpmos/dio.scs" section=tm
include "/pkg/xfab/XKIT/xh018/cadence/v8_0/spectre/v8_0_1/lpmos/mos.scs" section=tm
include "/pkg/xfab/XKIT/xh018/cadence/v8_0/spectre/v8_0_1/lpmos/photo.scs" section=tm
include "/pkg/xfab/XKIT/xh018/cadence/v8_0/spectre/v8_0_1/lpmos/res.scs" section=tm

// CHARACTERIZATION/BIAS_NMOS/schematic
subckt BIAS_NMOS
parameters WF L NF IDS VDS
    M0 (D G 0 0) ne w=WF l=L m=(1)*(NF)
    I0 (0 D) isource dc=IDS type=dc
    V1 (net6 0) vsource dc=VDS type=dc
    E0 (G 0 D net6) vcvs gain=1000
ends BIAS_NMOS

// CHARACTERIZATION/BIAS_PMOS/schematic
subckt BIAS_PMOS
parameters WF L NF IDS VDS
    M0 (D G S S) pe w=WF l=L m=(1)*(NF)
    E0 (S G net5 D) vcvs gain=1000
    I0 (D S) isource dc=IDS type=dc
    V0 (S 0) vsource dc=1.8 type=dc
    V1 (S net5) vsource dc=VDS type=dc
ends BIAS_PMOS

// CHARACTERIZATION/FAST_BIAS/schematic
I2 BIAS_NMOS WF=WF3 L=L3 NF=NF3 IDS=IDS3 VDS=VDS3
I1 BIAS_NMOS WF=WF2 L=L2 NF=NF2 IDS=IDS2 VDS=VDS2
I0 BIAS_NMOS WF=WF1 L=L1 NF=NF1 IDS=IDS1 VDS=VDS1
I5 BIAS_PMOS WF=WF6 L=L6 NF=NF6 IDS=IDS6 VDS=VDS6
I4 BIAS_PMOS WF=WF5 L=L5 NF=NF5 IDS=IDS5 VDS=VDS5
I3 BIAS_PMOS WF=WF4 L=L4 NF=NF4 IDS=IDS4 VDS=VDS4
simulatorOptions options reltol=100e-6 temp=27 homotopy=all limit=delta compatible=spice2
dcOp dc
