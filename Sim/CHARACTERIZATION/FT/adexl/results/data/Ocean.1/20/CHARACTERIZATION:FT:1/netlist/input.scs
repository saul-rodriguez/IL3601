// Design: CHARACTERIZATION/FT
simulator lang=spectre
global 0
parameters IDS WF=1e-6 VDS=1 NF=1 L=180e-9 IDS1=79.43282347u
include "/pkg/xfab/XKIT/xh018/cadence/v8_0/spectre/v8_0_1/lpmos/config.scs" section=default
include "/pkg/xfab/XKIT/xh018/cadence/v8_0/spectre/v8_0_1/lpmos/param.scs" section=3s
include "/pkg/xfab/XKIT/xh018/cadence/v8_0/spectre/v8_0_1/lpmos/bip.scs" section=tm
include "/pkg/xfab/XKIT/xh018/cadence/v8_0/spectre/v8_0_1/lpmos/cap.scs" section=tm
include "/pkg/xfab/XKIT/xh018/cadence/v8_0/spectre/v8_0_1/lpmos/dio.scs" section=tm
include "/pkg/xfab/XKIT/xh018/cadence/v8_0/spectre/v8_0_1/lpmos/mos.scs" section=tm
include "/pkg/xfab/XKIT/xh018/cadence/v8_0/spectre/v8_0_1/lpmos/photo.scs" section=tm
include "/pkg/xfab/XKIT/xh018/cadence/v8_0/spectre/v8_0_1/lpmos/res.scs" section=tm

// CHARACTERIZATION/FT/schematic
V1 (net10 0) vsource dc=VDS type=dc
I0 (0 D) isource dc=IDS type=dc
M0 (D G 0 0) ne w=WF l=L m=(1)*(NF)
E0 (net11 0 net5 net10) vcvs gain=1000
R1 (G net11) resistor r=10M
R0 (D net5) resistor r=10M
C1 (net7 D) capacitor c=1
C0 (net5 0) capacitor c=1
IPRB0 (0 net7) iprobe
I3 (0 G) isource mag=1 type=sine
simulatorOptions options reltol=100e-6 temp=27 homotopy=all limit=delta compatible=spice2
ac ac start=1 stop=100G dec=10
save IPRB0:in
