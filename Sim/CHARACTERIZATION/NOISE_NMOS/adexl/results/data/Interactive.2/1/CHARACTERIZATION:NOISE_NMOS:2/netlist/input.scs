// Design: CHARACTERIZATION/NOISE_NMOS
simulator lang=spectre
global 0
parameters IDS=10u L=1u NF=1 VDS=1 WF=10u
include "/pkg/xfab/XKIT/xh018/cadence/v8_0/spectre/v8_0_1/lpmos/config.scs" section=default
include "/pkg/xfab/XKIT/xh018/cadence/v8_0/spectre/v8_0_1/lpmos/param.scs" section=3s
include "/pkg/xfab/XKIT/xh018/cadence/v8_0/spectre/v8_0_1/lpmos/bip.scs" section=tm
include "/pkg/xfab/XKIT/xh018/cadence/v8_0/spectre/v8_0_1/lpmos/cap.scs" section=tm
include "/pkg/xfab/XKIT/xh018/cadence/v8_0/spectre/v8_0_1/lpmos/dio.scs" section=tm
include "/pkg/xfab/XKIT/xh018/cadence/v8_0/spectre/v8_0_1/lpmos/mos.scs" section=tm
include "/pkg/xfab/XKIT/xh018/cadence/v8_0/spectre/v8_0_1/lpmos/photo.scs" section=tm
include "/pkg/xfab/XKIT/xh018/cadence/v8_0/spectre/v8_0_1/lpmos/res.scs" section=tm

// CHARACTERIZATION/NOISE_NMOS/schematic
V0 (net015 0) vsource dc=VDS type=dc
V1 (net8 0) vsource dc=VDS type=dc
I5 (0 net08) isource dc=IDS type=dc
I0 (0 net03) isource dc=IDS type=dc
M1 (net08 net05 0 0) ne w=WF l=L m=(1)*(NF)
M0 (net03 net04 0 0) ne w=WF l=L m=(1)*(NF)
E1 (net016 0 net08 net015) vcvs gain=1000
E0 (net9 0 net03 net8) vcvs gain=1000
C4 (net05 net021) capacitor c=1
C3 (net08 0) capacitor c=1
C2 (net013 net08) capacitor c=1
C1 (net5 net03) capacitor c=1
C0 (net03 0) capacitor c=1
R1 (net05 net016) resistor r=100M
R0 (net04 net9) resistor r=100M
IPRB1 (0 net013) iprobe
IPRB0 (0 net5) iprobe
I6 (0 net04) isource mag=1 type=sine
V2 (net021 0) vsource mag=1 type=sine
simulatorOptions options reltol=100e-6 temp=27 homotopy=all limit=delta compatible=spice2
dcOp dc
noise noise start=0.01 stop=100G dec=10 oprobe=IPRB0 iprobe=I6
